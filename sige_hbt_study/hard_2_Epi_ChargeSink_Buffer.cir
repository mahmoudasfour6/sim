* Cryogenic 77K Heavy-Ion SEE Hardening Comparison (2_Epi_ChargeSink_Buffer)
VCC vdd 0 DC 1.8
RL vdd out 150
CL out 0 1.8000e-14
Cmu out b_int 2.2f
Rb b_int 0 18.0
Cpi b_int 0 48.2f
Vsense out ion_n DC 0.0
Iion ion_n 0 EXP(0 2.99415e-03 10p 9.5000e-13 12p 9.5000e-12)
.tran 0.4p 100p
.print tran i(Vsense) v(out)
.end
