* Strained SiGe HBT Cryogenic LNA Small-Signal AC Verification (77K_1Mrad_TID)
Vin in 0 AC 1.0
Rs in b_ext 50
Rb b_ext b_int 18.0
Rpi b_int 0 13942.9961
Cpi b_int 0 5.8871e-14
Cmu b_int out 2.2e-15
Gm out 0 b_int 0 7.53540e-02
Ro out 0 8500
RL out 0 150
.ac dec 20 100Meg 200G
.print ac vm(out) vp(out)
.end
