* W5 Mixed-Mode Ngspice SRAM SEU Check
Vdd vdd 0 DC 1.8
Rpull vdd q_node 2200
Cnode q_node 0 25f
Irad q_node 0 PWL(0.0000e+00 0.00000e+00 1.0000e-12 4.74708e-04 1.3709e-12 6.34874e-04 1.8793e-12 8.41330e-04 2.5763e-12 1.10099e-03 3.5318e-12 1.41618e-03 4.8417e-12 1.77907e-03 6.6373e-12 2.16373e-03 9.0990e-12 2.51727e-03 1.2474e-11 2.75565e-03 1.7100e-11 2.76765e-03 2.3442e-11 2.67183e-03 3.2136e-11 2.54585e-03 4.4054e-11 2.38274e-03 6.0393e-11 2.17598e-03 8.2791e-11 1.92138e-03 1.1350e-10 1.62005e-03 1.5559e-10 1.28224e-03 2.1330e-10 9.30552e-04 2.9240e-10 5.99620e-04 4.0085e-10 3.28265e-04 5.4951e-10 1.43725e-04 7.5332e-10 4.63243e-05 1.0327e-09 9.81106e-06 1.4157e-09 1.16847e-06 1.9408e-09 6.32104e-08 2.6606e-09 1.15910e-09 3.6473e-09 4.82351e-12 5.0000e-09 2.62804e-15)
.ic V(q_node)=1.8
.tran 5p 3n uic
.print tran V(q_node)
.end
